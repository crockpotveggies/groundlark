Groundlark Trenz support check: dc_3.3806912721675157_0.1
Vsource src 0 3.3806912721675157
Rpath src module 0.015
Iload module 0 0.1
Cbulk module 0 26.4u
.tran 1u 100u
.measure tran vmodule FIND v(module) AT=99u
.end
