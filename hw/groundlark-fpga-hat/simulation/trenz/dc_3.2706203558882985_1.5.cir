Groundlark Trenz support check: dc_3.2706203558882985_1.5
Vsource src 0 3.2706203558882985
Rpath src module 0.015
Iload module 0 1.5
Cbulk module 0 26.4u
.tran 1u 100u
.measure tran vmodule FIND v(module) AT=99u
.end
